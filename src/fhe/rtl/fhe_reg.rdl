// SPDX-License-Identifier: Apache-2.0
//
// Licensed under the Apache License, Version 2.0 (the "License");
// you may not use this file except in compliance with the License.
// You may obtain a copy of the License at
//
// http://www.apache.org/licenses/LICENSE-2.0
//
// Unless required by applicable law or agreed to in writing, software
// distributed under the License is distributed on an "AS IS" BASIS,
// WITHOUT WARRANTIES OR CONDITIONS OF ANY KIND, either express or implied.
// See the License for the specific language governing permissions and
// limitations under the License.
//
// CKKS FHE (Aloha) accelerator register map, version 2.
// Specification: docs/fhe/16-register-map-v2.md in the Chipyard checkout.
//
// Regenerate fhe_reg.sv / fhe_reg_pkg.sv / fhe_reg_uvm.sv with
//   python3 tools/scripts/reg_gen.py src/fhe/rtl/fhe_reg.rdl
// using the tool versions pinned in README.md.

addrmap fhe_reg {
    desc = "address map for the CKKS FHE accelerator register space";

    addressing = regalign;
    lsb0 = true;

    default hw = na;
    signal {activelow; async; cpuif_reset; field_reset;} reset_b;
    // Asserted while no command is accepted or running; gates parameter writes.
    signal {} fhe_ready;

    /* ---- Identity (RO) ---- */
    reg {
        name = "FHE component name";
        default sw = r;
        default hw = w;
        field {desc = "Name field";} NAME[32];
    } FHE_NAME[2] @ 0x0;

    reg {
        name = "FHE component version";
        default sw = r;
        default hw = w;
        field {desc = "Version field";} VERSION[32];
    } FHE_VERSION[2] @ 0x8;

    /* ---- Control (external: decoded in fhe_top, reads 0) ---- */
    external reg {
        name = "FHE control";
        desc = "Command issue, zeroize and input commit. Reads return 0.";
        default sw = w;
        default hw = r;
        field {desc = "Command: 001 ENCRYPT, 010 KEYGEN, 100 DECRYPT, 101 RECOVER,
                       110 REFRESH. Accepted only while READY. 011 and 111 complete
                       with ERROR.";} CMD[3] = 3'b0;
        field {desc = "Abort any command, clear registers, key-valid state and the
                       latched KeyVault seed. Does not scrub SRAM.";} ZEROIZE = 1'b0;
        field {desc = "Release the ENCRYPT input-commit barrier. Effective only
                       while STATUS.COMMIT_WAIT.";} INPUT_COMMIT = 1'b0;
        field {desc = "Reserved";} RSVD[27] = 27'b0;
    } FHE_CTRL @ 0x10;

    /* ---- Status (RO) ---- */
    reg {
        name = "FHE status";
        default sw = r;
        default hw = w;
        default resetsignal = reset_b;
        field {desc = "Idle; a command or parameter write is accepted.";} READY = 1'b0;
        field {desc = "The last command completed. Becomes visible in the same cycle as READY.";} VALID = 1'b0;
        field {desc = "The last command failed; see ERR_CAUSE.";} ERROR = 1'b0;
        field {desc = "A secret key from a successful KEYGEN is resident.";} KEY_VALID = 1'b0;
        field {desc = "Error cause: 0 none, 1 no key, 2 L out of range, 3 illegal opcode,
                       4 no fresh seed, 5 KeyVault read error, 6 DMA busy, 7 LOGN mismatch,
                       8 bad input word, 9 bad slot address, 10 transport error,
                       11 aborted by ZEROIZE.";} ERR_CAUSE[4] = 4'b0;
        field {desc = "ENCRYPT inputs are loaded; waiting for CTRL.INPUT_COMMIT.";} COMMIT_WAIT = 1'b0;
        field {desc = "Aloha holds the DMA lease.";} DMA_LEASED = 1'b0;
        field {desc = "Reserved";} RSVD[22] = 22'b0;
    } FHE_STATUS @ 0x14;

    /* ---- Command parameters ---- */
    reg {
        name = "FHE command configuration";
        default sw = rw;
        default hw = r;
        default swwe = fhe_ready;
        default hwclr = true;
        default resetsignal = reset_b;
        field {desc = "Limb count: limbs emitted by ENCRYPT/RECOVER, target limbs for REFRESH.
                       Ignored by KEYGEN and DECRYPT.";} L[4] = 4'b0;
        field {desc = "log2 N. Must equal the built ring dimension.";} LOGN[4] = 4'b0;
        field {desc = "Reserved"; sw = r; hw = na; swwe = false; hwclr = false;} RSVD0[8] = 8'b0;
        field {desc = "Instruction scale field; meaning depends on the command
                       (RNS encode field for KEYGEN/ENCRYPT, I2F field in [8:0] for DECRYPT).";} SCALE[12] = 12'b0;
        field {desc = "Reserved"; sw = r; hw = na; swwe = false; hwclr = false;} RSVD1[4] = 4'b0;
    } FHE_CONFIG @ 0x18;

    reg {
        name = "FHE capabilities";
        default sw = r;
        default hw = w;
        field {desc = "Ring dimension N";} N[16];
        field {desc = "Installed limbs";} L[4];
        field {desc = "FFT twiddles generated (no stored table)";} FFT_GENERATED = 1'b0;
        field {desc = "Reserved";} RSVD0[3];
        field {desc = "Direct DMA stream transport present";} DMA_STREAM = 1'b0;
        field {desc = "Firmware-forward stream (XFER_DATA) present";} FW_STREAM = 1'b0;
        field {desc = "Reserved";} RSVD1[2];
        field {desc = "Register map version";} MAP_VERSION[4];
    } FHE_CAP @ 0x1C;

    /* ---- KeyVault seed read (standard Caliptra KeyVault control) ---- */
    kv_read_ctrl_reg  FHE_KV_RD_SEED_CTRL   @ 0x20;
    kv_status_reg     FHE_KV_RD_SEED_STATUS @ 0x24;

    /* ---- Transfer status (RO) ---- */
    reg {
        name = "FHE transfer status";
        default sw = r;
        default hw = w;
        field {desc = "A transfer segment is open";} ACTIVE = 1'b0;
        field {desc = "Direction: 1 = output from Aloha";} DIR = 1'b0;
        field {desc = "Firmware-forward build: XFER_DATA may be written";} IN_READY = 1'b0;
        field {desc = "Firmware-forward build: XFER_DATA may be read";} OUT_VALID = 1'b0;
        field {desc = "Slot: 0 message/c0 in, 1 c1 in, 2 c0/slots/residues out, 3 c1 out";} SLOT[3] = 3'b0;
        field {desc = "Reserved";} RSVD0 = 1'b0;
        field {desc = "Limb";} LIMB[4] = 4'b0;
        field {desc = "Firmware-forward build: next XFER_DATA access is the high word";} HALF = 1'b0;
        field {desc = "Reserved";} RSVD1[19] = 19'b0;
    } FHE_XFER_STATUS @ 0x28;

    reg {
        name = "FHE transfer words left";
        default sw = r;
        default hw = w;
        field {desc = "64-bit words left in the current segment";} LEFT[32];
    } FHE_XFER_LEFT @ 0x2C;

    /* ---- Slot base addresses ---- */
    regfile fhe_slot_t {
        reg {
            name = "Slot base address, low word";
            default sw = rw;
            default hw = r;
            default swwe = fhe_ready;
            default hwclr = true;
            default resetsignal = reset_b;
            field {desc = "Address bits [31:0]";} ADDR[32] = 32'b0;
        } BASE_L;
        reg {
            name = "Slot base address, high word";
            default sw = rw;
            default hw = r;
            default swwe = fhe_ready;
            default hwclr = true;
            default resetsignal = reset_b;
            field {desc = "Address bits [63:32]";} ADDR[32] = 32'b0;
        } BASE_H;
    };
    fhe_slot_t FHE_SLOT[4] @ 0x30;

    /* ---- Firmware-forward data window (external; bring-up build only) ---- */
    external reg {
        name = "FHE transfer data";
        desc = "Firmware-forward build: two 32-bit accesses per 64-bit word, low word first.
                Other builds: reads 0, writes return an AHB error.";
        default sw = rw;
        default hw = rw;
        field {desc = "Data";} DATA[32] = 32'b0;
    } FHE_XFER_DATA @ 0x50;
};
